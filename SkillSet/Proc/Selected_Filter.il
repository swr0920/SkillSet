procedure( Selected_Filter()
  case( envGetVal("schematic" "schematicSelectFilter" `string)
            ("allSchObj instancePin"                            _schUpdateSelFilterForm('instances) )
            ("instance"                                         _schUpdateSelFilterForm('nets)      )
            ("wire"                                             _schUpdateSelFilterForm('pins)      )
            ("pin"                                              _schUpdateSelFilterForm('text)      )
            ("wireName allInstObj noteText noteShape pinName"   _schUpdateSelFilterForm('default)   )
      )
)
